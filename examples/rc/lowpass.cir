Synthetic RC step fixture; not a component qualification model
Vstep input 0 PULSE(0 1 1m 1u 1u 20m 40m)
R1 input output 1k
C1 output 0 1u
.save V(input) V(output) I(Vstep)
.tran 10u 10m 0 10u
.end
